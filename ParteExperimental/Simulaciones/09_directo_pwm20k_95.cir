* 09 - Diseno elegido con PWM de 20 kHz y ciclo de trabajo del 95 %
Vpin src 0 PULSE(0 5 0 20n 20n 4.75e-05 50u)
* Salida del Arduino: ~25 ohm de resistencia de salida (valor aproximado)
Rout src d9 25
R1 d9 g 180
R2 g 0 10k
M1 dr g 0 IRFZ44N
.save V(d9) V(g) V(dr) I(Lm) I(D1) I(Rout) V(vbus) Id(M1)
.include comun_motor.inc
.tran 0 3m 0 0.2u
* Regimen permanente: ultimo milisegundo (20 periodos)
.meas tran Id_prom AVG I(Lm) FROM=2m TO=3m
.meas tran Id_pp PP I(Lm) FROM=2m TO=3m
.meas tran P_Q1_prom AVG V(dr)*Id(M1) FROM=2m TO=3m
.meas tran P_D1_prom AVG (V(dr)-V(vbus))*I(D1) FROM=2m TO=3m
.meas tran Vmotor_prom AVG V(vbus)-V(dr) FROM=2m TO=3m
.end
