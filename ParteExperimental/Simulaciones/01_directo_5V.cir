* 01 - DISENO ELEGIDO: pin del Arduino (5 V) directo a la compuerta (R1 180, R2 10k), driver en D9
Vpin src 0 PULSE(0 5 100u 20n 20n 1m 10m)
* Salida del Arduino: ~25 ohm de resistencia de salida (valor aproximado)
Rout src d9 25
R1 d9 g 180
R2 g 0 10k
M1 dr g 0 IRFZ44N
.save V(d9) V(g) V(dr) I(Lm) I(D1) I(Rout) V(vbus) Id(M1)
.meas tran t_on TRIG V(d9) VAL=2.5 RISE=1 TARG V(dr) VAL=6 FALL=1
.meas tran t_off TRIG V(d9) VAL=2.5 FALL=1 TARG V(dr) VAL=6 RISE=1
.meas tran Ipin_pico MAX I(Rout)
.include comun_motor.inc
.include mediciones_escalon.inc
.end
