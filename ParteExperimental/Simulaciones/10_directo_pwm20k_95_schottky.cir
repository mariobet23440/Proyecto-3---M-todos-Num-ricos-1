* 10 - Como 09 (PWM 20 kHz, 95 %), pero con diodo Schottky MBRS340 en lugar del 1N540X
Vpin src 0 PULSE(0 5 0 20n 20n 4.75e-05 50u)
* Salida del Arduino: ~25 ohm de resistencia de salida (valor aproximado)
Rout src d9 25
R1 d9 g 180
R2 g 0 10k
M1 dr g 0 IRFZ44N
.save V(d9) V(g) V(dr) I(Lm) I(D1) I(Rout) V(vbus) Id(M1)
.include comun_motor.inc
* Reemplaza el diodo del archivo comun por un Schottky
.model 1N540X D(Is=22.6u Rs=.042 N=1.094 Cjo=480p M=.61 Eg=.69 Xti=2 Iave=3 Vpk=40 type=Schottky)
.tran 0 3m 0 0.2u
* Regimen permanente: ultimo milisegundo (20 periodos)
.meas tran Id_prom AVG I(Lm) FROM=2m TO=3m
.meas tran Id_pp PP I(Lm) FROM=2m TO=3m
.meas tran P_Q1_prom AVG V(dr)*Id(M1) FROM=2m TO=3m
.meas tran P_D1_prom AVG (V(dr)-V(vbus))*I(D1) FROM=2m TO=3m
.meas tran Vmotor_prom AVG V(vbus)-V(dr) FROM=2m TO=3m
.end
