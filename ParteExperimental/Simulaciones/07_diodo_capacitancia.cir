* 07 - Verificacion del modelo 1N540X: capacitancia de union a 1 MHz
* Tres copias del diodo, cada una polarizada en inversa a un voltaje distinto.
* C = |I| / (2*pi*f*1 V). Se usa 40 V como maximo porque el modelo tiene BV = 50 V
* (1N5400); el punto de 100 V de la hoja corresponde a los modelos de mayor tension.
V4 k4 0 DC 4 AC 1
D4 0 k4 1N540X
V10 k10 0 DC 10 AC 1
D10 0 k10 1N540X
V40 k40 0 DC 40 AC 1
D40 0 k40 1N540X
.include modelos/1N540X.lib
.ac list 1Meg
.meas AC I4 FIND mag(I(V4)) AT=1Meg
.meas AC I10 FIND mag(I(V10)) AT=1Meg
.meas AC I40 FIND mag(I(V40)) AT=1Meg
.end
